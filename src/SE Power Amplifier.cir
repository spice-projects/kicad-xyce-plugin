.TITLE KiCad schematic
.INCLUDE "/Users/rogelio/Projects/SE Power Amplifier/spice/159Y.LIB"
.INCLUDE "/Users/rogelio/Projects/SE Power Amplifier/spice/D1N5349B.LIB"
.INCLUDE "/Users/rogelio/Projects/SE Power Amplifier/spice/D20A10.LIB"
.INCLUDE "/Users/rogelio/Projects/SE Power Amplifier/spice/VS-E5TX0812-M3.LIB"
.MODEL __D201 D
.MODEL __D203 D
.MODEL __D202 D
.MODEL __D204 D
R216 GND VCC 3.1k
C201 VCC GND 2.2u
C203 /Power_Supply/B+ /Power_Supply/D1 10n
R215 HGND H2 8.4
D207 HGND H1 D1N5349B
VJ203 /Power_Supply/HAC1 /Power_Supply/HAC2 DC 0 SIN( 0 8.909 60 )
C213 /Power_Supply/B+ Net-_C213-Pad2_ 470u
C210 /Power_Supply/D4 GND 10n
C209 /Power_Supply/B+ /Power_Supply/D2 10n
R208 /Power_Supply/AC2 /Power_Supply/D4 20
C215 /Power_Supply/B+ GND 2.2u
C202 VCC GND 100u
XL201 VCC /Power_Supply/B+ HAMMOND_159Y_160MA
C204 /Power_Supply/D3 GND 10n
C207 Net-_C207-Pad1_ GND 10n
R210 /Power_Supply/B+ Net-_C213-Pad2_ 110k
R211 Net-_C213-Pad2_ GND 110k
C211 /Power_Supply/HB+ /Power_Supply/HAC1 10000u
C214 Net-_C213-Pad2_ GND 470u
D210 /Power_Supply/HAC2 /Power_Supply/HB+ 20A10
D211 HGND /Power_Supply/HAC2 20A10
C217 /Power_Supply/HAC2 HGND 10n
D206 GND /Power_Supply/D3 VS-E5TX0812-M3
D201 GND /Power_Supply/Earth1 __D201
D203 /Power_Supply/Earth1 GND __D203
R201 GND Earth 10
C205 GND Earth 0.047u
D202 Earth /Power_Supply/Earth1 __D202
D204 /Power_Supply/Earth1 Earth __D204
D205 /Power_Supply/D1 /Power_Supply/B+ VS-E5TX0812-M3
R202 /Power_Supply/D1 /Power_Supply/AC1 20
R203 /Power_Supply/AC1 /Power_Supply/D3 20
R205 /Power_Supply/AC2 Net-_C207-Pad1_ 10
R206 H2 /Power_Supply/HB+ 1
D209 GND /Power_Supply/D4 VS-E5TX0812-M3
R209 /Power_Supply/HB+ H1 6.2
R212 /Power_Supply/B+ HGND 1Meg
R213 HGND GND 200k
C216 /Power_Supply/HB+ /Power_Supply/HAC2 10n
R214 HGND H1 42
C206 Net-_C206-Pad1_ GND 10n
R204 /Power_Supply/AC1 Net-_C206-Pad1_ 10
VJ202 /Power_Supply/AC1 /Power_Supply/AC2 DC 0 SIN( 0 516.1 60 )
D208 /Power_Supply/D2 /Power_Supply/B+ VS-E5TX0812-M3
R207 /Power_Supply/D2 /Power_Supply/AC2 20
C208 H1 HGND 1000u
C212 /Power_Supply/HAC1 HGND 10000u
C218 HGND GND 0.1u

.PREPROCESS REPLACEGROUND TRUE
.TRAN 1u 10 0
.PRINT TRAN FORMAT=RAW I(*) V(*) P(*) W(*)

.END
