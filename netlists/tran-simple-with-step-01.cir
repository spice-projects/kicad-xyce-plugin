* Simple RLC Series Circuit - Transient Analysis Test
V1 IN 0 PULSE(0 5 0 1n 1n 10m 20m)
R1 IN N1 100
L1 N1 N2 10mH
C1 N2 0 1uF
.OPTIONS FFT FFTOUT=1

.PREPROCESS REPLACEGROUND TRUE
.TRAN 1u 20m 0
.PRINT TRAN FORMAT=RAW FILE=tran-simple-with-step-01.raw V(0) V(IN) V(N1) V(N2) I(V1) I(R1) I(L1) I(C1)
.FFT I(L1) WINDOW=HANN
.STEP L1 LIST 10mH 20mH 30mH

.END
