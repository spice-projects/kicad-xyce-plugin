* Simple 3-Port RLC Network - Linear S-Parameter (.LIN) Analysis Test
P1 IN1 0 port=1 z0=50 AC 1
P2 IN2 0 port=2 z0=50 AC 1
P3 IN3 0 port=3 z0=50 AC 1
R1 IN1 N1 50
R2 IN2 N2 50
R3 IN3 N3 50
C1 N1 N2 1nF
C2 N2 N3 1nF
C3 N3 N1 1nF

.PREPROCESS REPLACEGROUND FALSE
.AC DEC 20 1 100k
.LIN SPARCALC=1 FORMAT=TOUCHSTONE2 LINTYPE=S DATAFORMAT=RI FILE=lin-simple-02.s3p WIDTH=16 PRECISION=8
.PRINT AC FORMAT=RAW FILE=lin-simple-02.raw V(*) I(*)

.END
