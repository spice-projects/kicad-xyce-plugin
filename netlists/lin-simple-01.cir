* Simple 2-Port RLC Network - Linear S-Parameter (.LIN) Analysis Test
P1 IN 0 port=1 z0=50 AC 1
P2 OUT 0 port=2 z0=50 AC 1
R1 IN N1 100
L1 N1 N2 10mH
C1 N2 OUT 1uF

.PREPROCESS REPLACEGROUND TRUE
.AC LIN 20 1 100k
.LIN SPARCALC=1 FORMAT=TOUCHSTONE2 LINTYPE=S DATAFORMAT=RI FILE=lin-simple-01.s2p WIDTH=16 PRECISION=8
.PRINT AC FORMAT=RAW FILE=lin-simple-01.raw SR(1,1) SI(1,1) SM(1,1) SP(1,1) SDB(1,1) SR(2,1) SI(2,1) SM(2,1) SP(2,1) SDB(2,1) SR(1,2) SI(1,2) SM(1,2) SP(1,2) SDB(1,2) SR(2,2) SI(2,2) SM(2,2) SP(2,2) SDB(2,2)
.END
