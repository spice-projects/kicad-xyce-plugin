* RC Lowpass Network in a Subcircuit - Transient Analysis Test
V1 IN 0 PULSE(0 5 0 1n 1n 10m 20m)
XU1 IN OUT RCLOWPASS
R1 OUT 0 100k

.SUBCKT RCLOWPASS IN OUT
R1 IN N1 10k
C1 N1 OUT 100n
.ENDS RCLOWPASS

.PREPROCESS REPLACEGROUND TRUE
.TRAN 1u 20m 0
.PRINT TRAN FORMAT=RAW FILE=tran-subckt-01.raw V(*) I(*)

.END
