* DC nested sweep test — 3 nested LIN sweeps (RG §2.1.3)
V1 1 0 DC 0V
R1 1 2 1k
R2 2 0 1k

.PREPROCESS REPLACEGROUND TRUE
.DC V1 0 5 0.5 R1:R 1k 10k 1k TEMP 25 125 25
.PRINT DC FORMAT=RAW FILE=dc-sweep-nested-01.raw V(*) I(*)
.END
