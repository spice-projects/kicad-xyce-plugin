* DC Sweep with Resistor Stepping for Xyce

.PARAM R1_VAL = 1k
V1 1 0 DC 0V
R1 1 2 {R1_VAL}
R2 2 0 2k
.DC V1 0 5 0.5
.PRINT DC FORMAT=RAW FILE=dc-sweep-with-step-01.raw V(*) I(*)
.STEP R1_VAL LIST 1k 2k
.END
