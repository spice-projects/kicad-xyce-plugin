* Simple DC Sweep Example for Xyce

V1 1 0 DC 0V
R1 1 2 1k
R2 2 0 2k
.DC V1 0 5 0.5
.PRINT DC FORMAT=RAW FILE=dc-sweep-01.raw V(1) V(2) I(R1)
.END
